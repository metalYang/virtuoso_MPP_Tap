;返回一个更接近0，但与输入值相差小于1的数。
procedure(fix22(num)
	prog(()
		return(atoi(sprintf(nil "%f" num)))
	)
)
