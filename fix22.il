procedure(fix22(cv)
	prog(()
		return(atoi(sprintf(nil "%f" cv)))
	)
)
